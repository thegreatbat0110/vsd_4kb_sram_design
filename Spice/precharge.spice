** sch_path: /home/kaavya/chip/SRAM_SKY130/xschem/precharge.sch
**.subckt precharge
XM1 blb prechar VDD/2 VDD/2 sky130_fd_pr__pfet_01v8 L=0.21 W=0.84 nf=1 ad=0.2436 as=0.2436 pd=2.26 ps=2.26 nrd=0.345238095238095
+ nrs=0.345238095238095 sa=0 sb=0 sd=0 mult=1
XM2 bl prechar VDD/2 VDD/2 sky130_fd_pr__pfet_01v8 L=0.21 W=0.84 nf=1 ad=0.2436 as=0.2436 pd=2.26 ps=2.26 nrd=0.345238095238095
+ nrs=0.345238095238095 sa=0 sb=0 sd=0 mult=1
XM3 bl prechar blb blb sky130_fd_pr__pfet_01v8 L=0.21 W=0.84 nf=1 ad=0.2436 as=0.2436 pd=2.26 ps=2.26 nrd=0.345238095238095
+ nrs=0.345238095238095 sa=0 sb=0 sd=0 mult=1
**** begin user architecture code

.lib /home/kaavya/.ciel/ciel/sky130/versions/9233c19260cd813c3fa67dd4594fe4cc67016832/sky130A/libs.tech/ngspice/sky130.lib.spice tt
V1 VDD/2 gnd dc 1.8
V2 prechar gnd pulse 0 1.8 0 60ps 60ps 5ns 10ns

.tran 1n 50n
.control
run
plot V(prechar)+6 V(bl)+2 V(blb)
.endc

**** end user architecture code
**.ends
.GLOBAL VDD/2
.GLOBAL prechar
.end
