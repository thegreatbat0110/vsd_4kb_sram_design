** sch_path: /home/kaavya/chip/SRAM_SKY130/xschem/six_t_hold_snm.sch
**.subckt six_t_hold_snm
XM2 q2 qb2 0 0 sky130_fd_pr__nfet_01v8 L=0.21 W=0.42 nf=1 ad='int((nf+1)/2) * W/nf * 0.29' as='int((nf+2)/2) * W/nf * 0.29' pd='2*int((nf+1)/2) * (W/nf + 0.29)'
+ ps='2*int((nf+2)/2) * (W/nf + 0.29)' nrd='0.29 / W' nrs='0.29 / W' sa=0 sb=0 sd=0 mult=1
XM3 q1 qb1 0 0 sky130_fd_pr__nfet_01v8 L=0.21 W=0.42 nf=1 ad='int((nf+1)/2) * W/nf * 0.29' as='int((nf+2)/2) * W/nf * 0.29' pd='2*int((nf+1)/2) * (W/nf + 0.29)'
+ ps='2*int((nf+2)/2) * (W/nf + 0.29)' nrd='0.29 / W' nrs='0.29 / W' sa=0 sb=0 sd=0 mult=1
XM6 q2 qb2 VDD VDD sky130_fd_pr__pfet_01v8 L=0.21 W=0.84 nf=1 ad='int((nf+1)/2) * W/nf * 0.29' as='int((nf+2)/2) * W/nf * 0.29' pd='2*int((nf+1)/2) * (W/nf + 0.29)'
+ ps='2*int((nf+2)/2) * (W/nf + 0.29)' nrd='0.29 / W' nrs='0.29 / W' sa=0 sb=0 sd=0 mult=1
XM7 q1 qb1 VDD VDD sky130_fd_pr__pfet_01v8 L=0.21 W=0.84 nf=1 ad='int((nf+1)/2) * W/nf * 0.29' as='int((nf+2)/2) * W/nf * 0.29' pd='2*int((nf+1)/2) * (W/nf + 0.29)'
+ ps='2*int((nf+2)/2) * (W/nf + 0.29)' nrd='0.29 / W' nrs='0.29 / W' sa=0 sb=0 sd=0 mult=1
v1 qb1 0 1.8
v2 qb2 0 1.8
**** begin user architecture code

.lib /home/kaavya/.ciel/ciel/sky130/versions/9233c19260cd813c3fa67dd4594fe4cc67016832/sky130A/libs.tech/ngspice/sky130.lib.spice tt
VDD VDD 0 1.8
.control

dc V1 0 1.8 0.01
wrdata curve_hold_1.txt v(qb1) v(q1)
dc V2 0 1.8 0.01
wrdata curve_hold_2.txt v(q2) v(qb2)
plot dc1.v(qb1) vs dc1.v(q1) dc2.v(q2) vs dc2.v(qb2)

.endc

**** end user architecture code
**.ends
.GLOBAL VDD
.end
