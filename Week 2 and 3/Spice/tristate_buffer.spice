** sch_path: /home/kaavya/chip/SRAM_SKY130/xschem/tristate_buffer.sch
**.subckt tristate_buffer
XM1 net1 IN VDD VDD sky130_fd_pr__pfet_01v8 L=0.15 W=0.55 nf=1 ad=0.1595 as=0.1595 pd=1.68 ps=1.68 nrd=0.527272727272727
+ nrs=0.527272727272727 sa=0 sb=0 sd=0 mult=1
XM2 net1 IN 0 0 sky130_fd_pr__nfet_01v8 L=0.15 W=0.42 nf=1 ad=0.1218 as=0.1218 pd=1.42 ps=1.42 nrd=0.69047619047619
+ nrs=0.69047619047619 sa=0 sb=0 sd=0 mult=1
XM3 net2 net1 VDD VDD sky130_fd_pr__pfet_01v8 L=0.15 W=0.55 nf=1 ad=0.1595 as=0.1595 pd=1.68 ps=1.68 nrd=0.527272727272727
+ nrs=0.527272727272727 sa=0 sb=0 sd=0 mult=1
XM4 OUT ENB net2 net2 sky130_fd_pr__pfet_01v8 L=0.15 W=0.55 nf=1 ad=0.1595 as=0.1595 pd=1.68 ps=1.68 nrd=0.527272727272727
+ nrs=0.527272727272727 sa=0 sb=0 sd=0 mult=1
XM5 OUT EN net3 0 sky130_fd_pr__nfet_01v8 L=0.15 W=0.42 nf=1 ad=0.1218 as=0.1218 pd=1.42 ps=1.42 nrd=0.69047619047619
+ nrs=0.69047619047619 sa=0 sb=0 sd=0 mult=1
XM6 net3 net1 0 0 sky130_fd_pr__nfet_01v8 L=0.15 W=0.42 nf=1 ad=0.1218 as=0.1218 pd=1.42 ps=1.42 nrd=0.69047619047619
+ nrs=0.69047619047619 sa=0 sb=0 sd=0 mult=1
**** begin user architecture code

.lib /home/kaavya/.ciel/ciel/sky130/versions/9233c19260cd813c3fa67dd4594fe4cc67016832/sky130A/libs.tech/ngspice/sky130.lib.spice tt
VDD VDD 0 1.8
Vin IN 0 pulse 0 1.8 0 10ps 10ps 5ns 10ns
Ven EN 0 pulse 0 1.8 0 10ps 10ps 20ns 40ns
Venb ENB 0 pulse 1.8 0 0 10ps 10ps 20ns 40ns
.tran 0.1ns 100ns

.control
run
plot v(in)+6 v(en)+4 v(enb)+2 v(out)
.endc

**** end user architecture code
**.ends
.GLOBAL IN
.GLOBAL VDD
.GLOBAL ENB
.GLOBAL EN
.end
